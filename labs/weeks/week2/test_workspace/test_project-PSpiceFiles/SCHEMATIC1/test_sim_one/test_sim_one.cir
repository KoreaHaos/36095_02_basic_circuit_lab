** Profile: "SCHEMATIC1-test_sim_one"  [ C:\Users\Ben-Setup\Desktop\test_workspace\test_project-PSpiceFiles\SCHEMATIC1\test_sim_one.sim ]

** Creating circuit file "test_sim_one.cir"
** WARNING: THIS AUTOMATICALLY GENERATED FILE MAY BE OVERWRITTEN BY SUBSEQUENT SIMULATIONS

*Libraries:
* Profile Libraries :
* Local Libraries :
* From [PSPICE NETLIST] section of C:\Users\Ben-Setup\AppData\Roaming\SPB_16.6\cdssetup\OrCAD_PSpice/16.6.0/PSpice.ini file:
.lib "nomd.lib"

*Analysis directives:
.DC LIN V_V1 0v 6v .1v
+ LIN V_V1 0 6V 0.1V
.OPTIONS ADVCONV
.PROBE64 V(alias(*)) I(alias(*)) W(alias(*)) D(alias(*)) NOISE(alias(*))
.INC "..\SCHEMATIC1.net"

.END
